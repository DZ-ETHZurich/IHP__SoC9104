$ Spice netlist generated by v2lvs
$ v2021.3_35.19    Wed Sep 1 15:25:12 PDT 2021
*.BUSDELIMITER [

.SUBCKT delay_line_D4_O1_6P000 clk_i clk_o[0] delay_i[3] delay_i[2] delay_i[1]
+ delay_i[0] VSS VDD
Xhold1 sg13g2_dlygate4sd3_1 $PINS X=net1 A=net47 VSS=VSS VDD=VDD
Xhold10 sg13g2_dlygate4sd3_1 $PINS X=net10 A=net11 VSS=VSS VDD=VDD
Xhold11 sg13g2_dlygate4sd3_1 $PINS X=net11 A=net47 VSS=VSS VDD=VDD
Xhold12 sg13g2_dlygate4sd3_1 $PINS X=net12 A=net13 VSS=VSS VDD=VDD
Xhold13 sg13g2_dlygate4sd3_1 $PINS X=net13 A=net15 VSS=VSS VDD=VDD
Xhold14 sg13g2_dlygate4sd3_1 $PINS X=net14 A=net12 VSS=VSS VDD=VDD
Xhold15 sg13g2_dlygate4sd2_1 $PINS X=net15 A=net47 VSS=VSS VDD=VDD
Xhold16 sg13g2_dlygate4sd3_1 $PINS X=net16 A=net18 VSS=VSS VDD=VDD
Xhold17 sg13g2_dlygate4sd3_1 $PINS X=net17 A=net20 VSS=VSS VDD=VDD
Xhold18 sg13g2_dlygate4sd3_1 $PINS X=net18 A=net21 VSS=VSS VDD=VDD
Xhold19 sg13g2_dlygate4sd3_1 $PINS X=net19 A=net16 VSS=VSS VDD=VDD
Xhold2 sg13g2_dlygate4sd3_1 $PINS X=net2 A=net3 VSS=VSS VDD=VDD
Xhold20 sg13g2_dlygate4sd3_1 $PINS X=net20 A=clk_l3m3o0 VSS=VSS VDD=VDD
Xhold21 sg13g2_dlygate4sd2_1 $PINS X=net21 A=net47 VSS=VSS VDD=VDD
Xhold22 sg13g2_dlygate4sd3_1 $PINS X=net22 A=net23 VSS=VSS VDD=VDD
Xhold23 sg13g2_dlygate4sd3_1 $PINS X=net23 A=net25 VSS=VSS VDD=VDD
Xhold24 sg13g2_dlygate4sd3_1 $PINS X=net24 A=net22 VSS=VSS VDD=VDD
Xhold25 sg13g2_dlygate4sd3_1 $PINS X=net25 A=net47 VSS=VSS VDD=VDD
Xhold28 sg13g2_dlygate4sd3_1 $PINS X=net28 A=net32 VSS=VSS VDD=VDD
Xhold29 sg13g2_dlygate4sd3_1 $PINS X=net29 A=net34 VSS=VSS VDD=VDD
Xhold3 sg13g2_dlygate4sd3_1 $PINS X=net3 A=net47 VSS=VSS VDD=VDD
Xhold30 sg13g2_dlygate4sd1_1 $PINS X=net30 A=net40 VSS=VSS VDD=VDD
Xhold32 sg13g2_dlygate4sd3_1 $PINS X=net32 A=clk_l3m4o0 VSS=VSS VDD=VDD
Xhold33 sg13g2_dlygate4sd3_1 $PINS X=net33 A=net28 VSS=VSS VDD=VDD
Xhold34 sg13g2_dlygate4sd3_1 $PINS X=net34 A=clk_l2m2o0 VSS=VSS VDD=VDD
Xhold35 sg13g2_dlygate4sd3_1 $PINS X=net35 A=net29 VSS=VSS VDD=VDD
Xhold39 sg13g2_dlygate4sd3_1 $PINS X=net39 A=net45 VSS=VSS VDD=VDD
Xhold4 sg13g2_dlygate4sd3_1 $PINS X=net4 A=net5 VSS=VSS VDD=VDD
Xhold41 sg13g2_dlygate4sd3_1 $PINS X=net41 A=net44 VSS=VSS VDD=VDD
Xhold42 sg13g2_dlygate4sd3_1 $PINS X=net42 A=net39 VSS=VSS VDD=VDD
Xhold44 sg13g2_dlygate4sd3_1 $PINS X=net44 A=clk_l3m5o0 VSS=VSS VDD=VDD
Xhold45 sg13g2_dlygate4sd3_1 $PINS X=net45 A=net41 VSS=VSS VDD=VDD
Xhold49 sg13g2_dlygate4sd3_1 $PINS X=net49 A=net58 VSS=VSS VDD=VDD
Xhold5 sg13g2_dlygate4sd3_1 $PINS X=net5 A=net6 VSS=VSS VDD=VDD
Xhold50 sg13g2_buf_2 $PINS X=net50 A=net37 VSS=VSS VDD=VDD
Xhold52 sg13g2_dlygate4sd3_1 $PINS X=net52 A=net57 VSS=VSS VDD=VDD
Xhold53 sg13g2_dlygate4sd3_1 $PINS X=net53 A=net59 VSS=VSS VDD=VDD
Xhold54 sg13g2_dlygate4sd3_1 $PINS X=net54 A=net36 VSS=VSS VDD=VDD
Xhold55 sg13g2_buf_2 $PINS X=net55 A=net38 VSS=VSS VDD=VDD
Xhold57 sg13g2_dlygate4sd3_1 $PINS X=net57 A=clk_l3m6o0 VSS=VSS VDD=VDD
Xhold58 sg13g2_dlygate4sd3_1 $PINS X=net58 A=net52 VSS=VSS VDD=VDD
Xhold59 sg13g2_dlygate4sd3_1 $PINS X=net59 A=net49 VSS=VSS VDD=VDD
Xhold6 sg13g2_dlygate4sd2_1 $PINS X=net6 A=net47 VSS=VSS VDD=VDD
Xhold60 sg13g2_dlygate4sd3_1 $PINS X=net60 A=net53 VSS=VSS VDD=VDD
Xhold64 sg13g2_dlygate4sd3_1 $PINS X=net64 A=net70 VSS=VSS VDD=VDD
Xhold66 sg13g2_dlygate4sd3_1 $PINS X=net66 A=net75 VSS=VSS VDD=VDD
Xhold67 sg13g2_buf_2 $PINS X=net67 A=net71 VSS=VSS VDD=VDD
Xhold69 sg13g2_dlygate4sd3_1 $PINS X=net69 A=net27 VSS=VSS VDD=VDD
Xhold7 sg13g2_dlygate4sd3_1 $PINS X=net7 A=net10 VSS=VSS VDD=VDD
Xhold70 sg13g2_dlygate4sd3_1 $PINS X=net70 A=net66 VSS=VSS VDD=VDD
Xhold71 sg13g2_dlygate4sd1_1 $PINS X=net71 A=net64 VSS=VSS VDD=VDD
Xhold72 sg13g2_buf_2 $PINS X=net72 A=net67 VSS=VSS VDD=VDD
Xhold74 sg13g2_dlygate4sd3_1 $PINS X=net74 A=net26 VSS=VSS VDD=VDD
Xhold75 sg13g2_dlygate4sd3_1 $PINS X=net75 A=net31 VSS=VSS VDD=VDD
Xhold8 sg13g2_dlygate4sd3_1 $PINS X=net8 A=clk_l3m2o0 VSS=VSS VDD=VDD
Xi_mx_l0m0o0 sg13g2_mux2_2 $PINS X=net46 A0=clk_l1m0o0 A1=net43 S=delay_i[3]
+ VSS=VSS VDD=VDD
Xi_mx_l1m0o0 sg13g2_mux2_1 $PINS X=clk_l1m0o0 A0=clk_l2m0o0 A1=clk_l2m1o0
+ S=delay_i[2] VSS=VSS VDD=VDD
Xi_mx_l1m1o0 sg13g2_mux2_1 $PINS X=clk_l1m1o0 A0=net35 A1=net55 S=delay_i[2]
+ VSS=VSS VDD=VDD
Xi_mx_l2m0o0 sg13g2_mux2_1 $PINS X=clk_l2m0o0 A0=clk_l3m0o0 A1=clk_l3m1o0
+ S=delay_i[1] VSS=VSS VDD=VDD
Xi_mx_l2m1o0 sg13g2_mux2_1 $PINS X=clk_l2m1o0 A0=net8 A1=net17 S=delay_i[1]
+ VSS=VSS VDD=VDD
Xi_mx_l2m2o0 sg13g2_mux2_1 $PINS X=clk_l2m2o0 A0=net33 A1=net42 S=delay_i[1]
+ VSS=VSS VDD=VDD
Xi_mx_l2m3o0 sg13g2_mux2_1 $PINS X=clk_l2m3o0 A0=net60 A1=net72 S=delay_i[1]
+ VSS=VSS VDD=VDD
Xi_mx_l3m0o0 sg13g2_mux2_1 $PINS X=clk_l3m0o0 A0=net47 A1=net1 S=delay_i[0]
+ VSS=VSS VDD=VDD
Xi_mx_l3m1o0 sg13g2_mux2_1 $PINS X=clk_l3m1o0 A0=net2 A1=net4 S=delay_i[0]
+ VSS=VSS VDD=VDD
Xi_mx_l3m2o0 sg13g2_mux2_1 $PINS X=clk_l3m2o0 A0=net7 A1=net14 S=delay_i[0]
+ VSS=VSS VDD=VDD
Xi_mx_l3m3o0 sg13g2_mux2_1 $PINS X=clk_l3m3o0 A0=net19 A1=net24 S=delay_i[0]
+ VSS=VSS VDD=VDD
Xi_mx_l3m4o0 sg13g2_mux2_1 $PINS X=clk_l3m4o0 A0=net51 A1=net51 S=delay_i[0]
+ VSS=VSS VDD=VDD
Xi_mx_l3m5o0 sg13g2_mux2_1 $PINS X=clk_l3m5o0 A0=net51 A1=net48 S=delay_i[0]
+ VSS=VSS VDD=VDD
Xi_mx_l3m6o0 sg13g2_mux2_1 $PINS X=clk_l3m6o0 A0=net9 A1=net63 S=delay_i[0]
+ VSS=VSS VDD=VDD
Xi_mx_l3m7o0 sg13g2_mux2_1 $PINS X=clk_l3m7o0 A0=net9 A1=net61 S=delay_i[0]
+ VSS=VSS VDD=VDD
Xhold9 sg13g2_buf_16 $PINS X=net9 A=net62 VSS=VSS VDD=VDD
Xhold26 sg13g2_dlygate4sd3_1 $PINS X=net26 A=clk_l3m7o0 VSS=VSS VDD=VDD
Xhold27 sg13g2_dlygate4sd2_1 $PINS X=net27 A=net74 VSS=VSS VDD=VDD
Xhold31 sg13g2_dlygate4sd3_1 $PINS X=net31 A=net69 VSS=VSS VDD=VDD
Xhold36 sg13g2_dlygate4sd3_1 $PINS X=net36 A=clk_l2m3o0 VSS=VSS VDD=VDD
Xhold37 sg13g2_dlygate4sd2_1 $PINS X=net37 A=net54 VSS=VSS VDD=VDD
Xhold38 sg13g2_buf_2 $PINS X=net38 A=net50 VSS=VSS VDD=VDD
Xhold40 sg13g2_dlygate4sd3_1 $PINS X=net40 A=clk_l1m1o0 VSS=VSS VDD=VDD
Xhold43 sg13g2_buf_2 $PINS X=net43 A=net30 VSS=VSS VDD=VDD
Xhold46 sg13g2_buf_8 $PINS X=clk_o[0] A=net46 VSS=VSS VDD=VDD
Xclone47 sg13g2_buf_16 $PINS X=net47 A=net62 VSS=VSS VDD=VDD
Xrebuffer48 sg13g2_dlygate4sd1_1 $PINS X=net48 A=net56 VSS=VSS VDD=VDD
Xrebuffer49 sg13g2_buf_1 $PINS X=net51 A=net9 VSS=VSS VDD=VDD
Xrebuffer50 sg13g2_dlygate4sd1_1 $PINS X=net56 A=net51 VSS=VSS VDD=VDD
Xrebuffer51 sg13g2_dlygate4sd1_1 $PINS X=net61 A=net9 VSS=VSS VDD=VDD
Xhold56 sg13g2_buf_16 $PINS X=net62 A=clk_i VSS=VSS VDD=VDD
Xhold61 sg13g2_dlygate4sd3_1 $PINS X=net63 A=net9 VSS=VSS VDD=VDD
.ENDS
